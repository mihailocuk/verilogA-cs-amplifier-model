simulator lang=spectre

// Include the Verilog-A model under test
ahdl_include "../src/cs_amplifier.va"

// Input stimulus:
// sine wave with 0 V DC offset, 10 mV amplitude, and 100 kHz frequency
// mag=1 defines the small-signal AC magnitude used in the AC analysis
Vin (in 0) vsource type=sine dc=0 ampl=10m freq=100k mag=1

// Instantiate the Device Under Test (DUT)
// The default parameter values defined in the Verilog-A model are used:
// A=10, Rin=1G, Rout=1k, fp1=1M, fp2=0
XU1 (in out 0) cs_amplifier

// Transient analysis:
// simulate 10 periods of the 100 kHz input signal
tran1 tran stop=100u maxstep=100n

// AC analysis:
// logarithmic frequency sweep from 10 Hz to 100 MHz
// with 20 points per decade
ac1 ac start=10 stop=100M dec=20

// Save the external input and output node voltages
save in out

// Save the internal dynamic nodes of the DUT
save XU1.int1 XU1.int2
